* Release 3 channel as drawn in KiCad (kicad/gen_amp.py, netlist-checked): release 2 circuit with (a) the bias trimmer moved
* to the base-emitter leg of the Vbe multiplier (750 / 750 + 500R trimmer: open wiper = minimum bias, maximum 75 mA),
* (b) a 2.2 uH output inductor with 10 R across it between the output capacitor and the speaker terminal.
.include models.inc
.model LEDR D(IS=1e-20 N=1.8 RS=10 CJO=20p)
Vcc vcc 0 DC 12
Vin in 0 DC 0 AC 0 SIN(0 0.1 1k)
Rs in src 2.5k
Cin b1 src 2.2u
Rb1 vcc bias 47k
Rb2 bias 0 47k
Cbias bias 0 47u
R3 bias b1 47k
* tail current source: LED 1.8 V below VCC, (1.8-0.65)/1.2k = 0.95 mA
Dled vcc led LEDR
Rled led 0 4.7k
Q9 tail led e9 BC557B
Rt vcc e9 1.2k
Q1 c1 b1 tail BC557B
Q2 c2 b2 tail BC557B
* current mirror load (diode side on Q2, output on Q1 -> VAS base)
Q8 c2 c2 e8 BC547B
Re8 e8 0 100
Q7 c1 c2 e7 BC547B
Re7 e7 0 100
Rf b2 fbk 22k
Vinj fbk out DC 0 AC 1
Cf b2 fbk 47p
Rg b2 g 1k
Cg g 0 220u
* VAS
Q3 b5 c1 e3 BC547B
Re3 e3 0 47
Cm b5 c1 220p
R5a vcc boot 270
R5b boot vas 270
Cboot boot out 100u
* bias and outputs
Q6 vas bm b5 BC547B
Rm1 vas bm 750
Rm2 bm m2 750
RV m2 b5 165
Q4 vcc vas e4 BD139
Q5 0 b5 e5 BD140
Re4 e4 out 0.47
Re5 out e5 0.47
Rzob out zz 10
Czob zz 0 100n
Cout out spk 1000u
Lo spk spkt 2.2u
Rlo spk spkt 10
RL spkt 0 8
CL spkt 0 1p
* VU meter tap: 1k from the speaker node to the VU header (the 10 Meg stands for the meter not being fitted)
Rvu spkt vu 1k
Rvumeter vu 0 10meg
* loop gain T = -v(out)/v(fbk), voltage injected in series with the feedback network at the output node
.control
foreach lo 1n 2.2u
  alter Lo = $lo
  foreach cl 1p 22n 47n 100n 470n 2.2u
    alter CL = $cl
    ac dec 100 10 100meg
    let t = -v(out)/v(fbk)
    let tdb = db(t)
    let ph = 180/pi*cph(t)
    meas ac t1k FIND tdb AT=1k
    meas ac t20k FIND tdb AT=20k
    meas ac fc WHEN tdb=0 FALL=1
    meas ac phc FIND ph WHEN tdb=0 FALL=1
    meas ac gm FIND tdb WHEN ph=-180 FALL=1
    let pm = 180 + phc
    echo RESULT loop lo=$lo cl=$cl t1k=$&t1k t20k=$&t20k fc=$&fc pm=$&pm gm=$&gm
  end
end
quit
.endc
.end
