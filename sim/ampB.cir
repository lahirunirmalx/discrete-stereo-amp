* Candidate B: BC547 diff pair, BC557 VAS with bootstrapped load, 2x 1N4148 bias, BD139/BD140 follower, 12 V single rail
.include models.inc
Vcc vcc 0 DC 12
Vin in 0 DC 0 AC 1 SIN(0 0.1 1k)
Rs in src 2.5k
Cin src b1 2.2u
* bias divider, decoupled, feeds Q1 base through R3
Rb1 vcc bias 47k
Rb2 bias 0 47k
Cbias bias 0 47u
R3 bias b1 47k
* diff pair
Q1 c1 b1 tail BC547B
Q2 vcc b2 tail BC547B
Rt tail 0 10k
Rc1 vcc c1 4.7k
* feedback: gain 1 + Rf/Rg
Rf out b2 22k
Rg b2 g 1k
Cg g 0 220u
* VAS
Q3 vas c1 e3 BC557B
Re3 vcc e3 100
Cm vas c1 100p
* bias diodes and bootstrapped load
D1 vas d12 D1N4148
D2 d12 b5 D1N4148
R5a b5 boot 680
R5b boot 0 680
Cboot out boot 100u
* output stage
Q4 vcc vas e4 BD139
Q5 0 b5 e5 BD140
Re4 e4 out 0.47
Re5 e5 out 0.47
Rzob out zz 10
Czob zz 0 100n
Cout out spk 1000u
RL spk 0 8
.control
foreach bf1 110 290 450
  altermod @BC547B[BF] = $bf1
  foreach bfo 40 120 250
    altermod @BD139[BF] = $bfo
    altermod @BD140[BF] = $bfo
    op
    let vo = v(out)
    let iq = i(Vcc)
    let iout = v(e4,out)/0.47
    echo RESULT op bf1=$bf1 bfo=$bfo vout=$&vo isupply=$&iq iqout=$&iout
  end
end
altermod @BC547B[BF] = 290
altermod @BD139[BF] = 120
altermod @BD140[BF] = 120
foreach rs 1 2500 5000
  alter Rs = $rs
  ac lin 1 1000 1000
  let g = mag(v(spk))
  let zin = mag(v(src)/i(Vin))
  echo RESULT ac rs=$rs gain=$&g zin=$&zin
end
alter Rs = 2500
alter RL = 4
ac dec 20 5 100k
meas ac g1k FIND vdb(spk) AT=1000
let tgt = g1k - 3
meas ac f3 WHEN vdb(spk)=tgt RISE=1
echo RESULT f3 rl=4 f3=$&f3
foreach rl 4 8 10
  alter RL = $rl
  foreach amp 0.03 0.1 0.2 0.3
    alter @Vin[sin] = [ 0 $amp 1k ]
    tran 5u 25m 15m
    meas tran vrms RMS v(spk) from=15m to=25m
    meas tran isup AVG i(Vcc) from=15m to=25m
    let p = vrms*vrms/$rl
    echo RESULT tran rl=$rl amp=$amp pout=$&p isupply=$&isup
    fourier 1k v(spk)
  end
end
quit
.endc
.end
