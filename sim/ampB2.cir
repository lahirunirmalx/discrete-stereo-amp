* Stereo amp channel, final candidate: BC547 diff pair, BC557 VAS (12 mA, bootstrapped), 2x 1N4148 bias, BD139/BD140 follower, 12 V single rail
.include models.inc
Vcc vcc 0 DC 12
Vin in 0 DC 0 AC 1 SIN(0 0.1 1k)
Rs in src 2.5k
Cin src b1 2.2u
Rb1 vcc bias 47k
Rb2 bias 0 47k
Cbias bias 0 47u
R3 bias b1 47k
Q1 c1 b1 tail BC547B
Q2 vcc b2 tail BC547B
Rt tail 0 10k
Rc1 vcc c1 4.7k
Rf out b2 22k
Rg b2 g 1k
Cg g 0 220u
Q3 vas c1 e3 BC557B
Re3 vcc e3 47
Cm vas c1 100p
D1 vas d12 D1N4148
D2 d12 b5 D1N4148
R5a b5 boot 270
R5b boot 0 270
Cboot out boot 100u
Q4 vcc vas e4 BD139
Q5 0 b5 e5 BD140
Re4 e4 out 0.47
Re5 e5 out 0.47
Rzob out zz 10
Czob zz 0 100n
Cout out spk 1000u
RL spk 0 8
CL spk 0 1p
.control
foreach bf1 110 450
  altermod @BC547B[BF] = $bf1
  foreach bfo 40 250
    altermod @BD139[BF] = $bfo
    altermod @BD140[BF] = $bfo
    op
    let vo = v(out)
    let iq = -i(Vcc)
    let iout = v(e4,out)/0.47
    let ivas = v(vcc,e3)/47
    echo RESULT op bf1=$bf1 bfo=$bfo vout=$&vo isupply=$&iq iqout=$&iout ivas=$&ivas
  end
end
altermod @BC547B[BF] = 290
altermod @BD139[BF] = 120
altermod @BD140[BF] = 120
foreach t 25 70
  option temp = $t
  op
  let iout = v(e4,out)/0.47
  let vo = v(out)
  echo RESULT temp t=$t iqout=$&iout vout=$&vo
end
option temp = 25
foreach rs 1 2500 5000
  alter Rs = $rs
  ac lin 1 1000 1000
  let g = mag(v(spk))
  let zin = mag(v(src)/i(Vin))
  echo RESULT ac rs=$rs gain=$&g zin=$&zin
end
alter Rs = 2500
foreach rl 4 8
  alter RL = $rl
  ac dec 20 5 1meg
  meas ac g1k FIND vdb(spk) AT=1000
  let tgt = g1k - 3
  meas ac f3 WHEN vdb(spk)=tgt RISE=1
  meas ac fh WHEN vdb(spk)=tgt FALL=1
  echo RESULT f3 rl=$rl f3=$&f3 fh=$&fh
end
foreach bfo 40 120
  altermod @BD139[BF] = $bfo
  altermod @BD140[BF] = $bfo
  foreach rl 4 8 10
    alter RL = $rl
    foreach amp 0.03 0.1 0.2 0.3 0.4
      alter @Vin[sin] = [ 0 $amp 1k ]
      tran 5u 25m 15m
      meas tran vrms RMS v(spk) from=15m to=25m
      meas tran isup AVG i(Vcc) from=15m to=25m
      let pq4v = (v(vcc)-v(e4))*v(e4,out)/0.47
      meas tran pq4 AVG pq4v from=15m to=25m
      let p = vrms*vrms/$rl
      echo RESULT tran bfo=$bfo rl=$rl amp=$amp pout=$&p isupply=$&isup pq4=$&pq4
      fourier 1k v(spk)
    end
  end
end
altermod @BD139[BF] = 120
altermod @BD140[BF] = 120
* 9 V rail, 4 ohm, dissipation and clipping
alter Vcc = 9
alter RL = 4
foreach amp 0.1 0.2 0.3
  alter @Vin[sin] = [ 0 $amp 1k ]
  tran 5u 25m 15m
  meas tran vrms RMS v(spk) from=15m to=25m
  meas tran isup AVG i(Vcc) from=15m to=25m
  let pq4v = (v(vcc)-v(e4))*v(e4,out)/0.47
  meas tran pq4 AVG pq4v from=15m to=25m
  let p = vrms*vrms/4
  echo RESULT tran9 rl=4 amp=$amp pout=$&p isupply=$&isup pq4=$&pq4
  fourier 1k v(spk)
end
alter Vcc = 12
* square wave, 8 ohm and 8 ohm || 100 nF
alter @Vin[sin] = [ 0 0 1k ]
alter Vin = pulse(-0.1 0.1 0 1u 1u 0.5m 1m)
foreach cl 1p 100n
  alter CL = $cl
  alter RL = 8
  alter RL = 8
  tran 1u 24m 20m
  meas tran vmax MAX v(spk) from=20m to=24m
  meas tran vset AVG v(spk) from=20.3m to=20.45m
  let os = (vmax - vset)/vset*100
  echo RESULT square cl=$cl vmax=$&vmax vset=$&vset overshoot_pct=$&os
end
quit
.endc
.end
