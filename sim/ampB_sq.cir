* Stereo amp channel, final candidate: BC547 diff pair, BC557 VAS (12 mA, bootstrapped), 2x 1N4148 bias, BD139/BD140 follower, 12 V single rail
.include models.inc
Vcc vcc 0 DC 12
Vin in 0 DC 0 PULSE(-0.1 0.1 0 1u 1u 0.5m 1m)
Rs in src 2.5k
Cin src b1 2.2u
Rb1 vcc bias 47k
Rb2 bias 0 47k
Cbias bias 0 47u
R3 bias b1 47k
Q1 c1 b1 tail BC547B
Q2 vcc b2 tail BC547B
Rt tail 0 10k
Rc1 vcc c1 4.7k
Rf out b2 22k
Rg b2 g 1k
Cg g 0 220u
Q3 vas c1 e3 BC557B
Re3 vcc e3 47
Cm vas c1 100p
D1 vas d12 D1N4148
Rbias d12 b5 22
R5a b5 boot 270
R5b boot 0 270
Cboot out boot 100u
Q4 vcc vas e4 BD139
Q5 0 b5 e5 BD140
Re4 e4 out 0.47
Re5 e5 out 0.47
Rzob out zz 10
Czob zz 0 100n
Cout out spk 1000u
RL spk 0 8
CL spk 0 1p
.control
foreach cl 1p 100n 470n
  alter CL = $cl
  tran 1u 24m 20m
  meas tran vmax MAX v(spk) from=20m to=24m
  meas tran vset AVG v(spk) from=20.3m to=20.45m
  let os = (vmax - vset)/vset*100
  echo RESULT square cl=$cl vmax=$&vmax vset=$&vset overshoot_pct=$&os
end
quit
.endc
.end
