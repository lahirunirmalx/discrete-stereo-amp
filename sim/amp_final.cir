* Stereo amp channel, final candidate: BC547 diff pair, BC557 VAS (12 mA, bootstrapped), 2x 1N4148 bias, BD139/BD140 follower, 12 V single rail
.include models.inc
Vcc vcc 0 DC 12
Vin in 0 DC 0 AC 1 SIN(0 0.1 1k)
Rs in src 2.5k
Cin b1 src 2.2u
Rb1 vcc bias 47k
Rb2 bias 0 47k
Cbias bias 0 47u
R3 bias b1 47k
Q1 c1 b1 tail BC547B
Q2 vcc b2 tail BC547B
Rt tail 0 10k
Rc1 vcc c1 4.7k
Rf b2 out 22k
Rg b2 g 1k
Cg g 0 220u
Q3 vas c1 e3 BC557B
Re3 vcc e3 47
Cm vas c1 100p
Q6 vas bm b5 BC547B
Rm1 vas m1 470
RV m1 bm 350
Rm2 bm b5 1k
R5a b5 boot 270
R5b boot 0 270
Cboot out boot 100u
Q4 vcc vas e4 BD139
Q5 0 b5 e5 BD140
Re4 e4 out 0.47
Re5 out e5 0.47
Rzob out zz 10
Czob zz 0 100n
Cout out spk 1000u
RL spk 0 8
CL spk 0 1p
.control
op
let iout = v(e4,out)/0.47
let vo = v(out)
echo RESULT op vout=$&vo iqout=$&iout
alter RL = 8
alter @Vin[sin] = [ 0 0.2 1k ]
tran 5u 25m 15m
meas tran vrms RMS v(spk) from=15m to=25m
let p = vrms*vrms/8
echo RESULT tran rl=8 amp=0.2 pout=$&p
fourier 1k v(spk)
quit
.endc
.end
