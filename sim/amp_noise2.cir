* Amp channel as built: input sensitivity, noise and gain vs source resistance (pot position)
.include models.inc
Vcc vcc 0 DC 12
Vin in 0 DC 0 AC 1
Rs in src 2.5k
Cin b1 src 2.2u
Rb1 vcc bias 47k
Rb2 bias 0 47k
Cbias bias 0 47u
R3 bias b1 47k
Q1 c1 b1 tail BC547B
Q2 vcc b2 tail BC547B
Rt tail 0 10k
Rc1 vcc c1 4.7k
Rf b2 out 22k
Rg b2 g 1k
Cg g 0 220u
Q3 vas c1 e3 BC557B
Re3 vcc e3 47
Cm vas c1 100p
Q6 vas bm b5 BC547B
Rm1 vas m1 470
RV m1 bm 350
Rm2 bm b5 1k
R5a b5 boot 270
R5b boot 0 270
Cboot out boot 100u
Q4 vcc vas e4 BD139
Q5 0 b5 e5 BD140
Re4 e4 out 0.47
Re5 out e5 0.47
Rzob out zz 10
Czob zz 0 100n
Cout out spk 1000u
RL spk 0 8
.control
foreach rs 1 2500 12500
  alter Rs = $rs
  noise v(spk) Vin dec 20 20 20k
  setplot previous
  wrdata /tmp/claude-1000/-home-lahiru-electronics-one-transister-amp/7d71810f-dd25-40b2-9122-51a7d604d444/scratchpad/noise_$rs onoise_spectrum inoise_spectrum
  ac lin 1 1000 1000
  let g = mag(v(spk))
  echo RESULT gain rs=$rs gain=$&g
end
quit
.endc
.end
