* PSU board: 12-15 VAC in, fuse, 4x 1N5401 bridge, 2x 2200u, zener (13 V) + BC547/TIP41C Darlington pass,
* 0.47 R current clamp, 1N4007 reverse diode across the pass, DC-in via SB540 Schottky into VOUT.
.options RELTOL=0.005 ABSTOL=1e-10 VNTOL=1e-7 CHGTOL=1e-14
.options TRTOL=7 ITL1=500 ITL4=500 GMIN=1e-11
Vac ac0 ac2 SIN(0 16.97 50)
Rfuse ac0 ac1 0.02
Rw ac2 ac2w 0.8
D1 ac1 vraw DMOD
D2 ac2w vraw DMOD
D3 0 ac1 DMOD
D4 0 ac2w DMOD
C1 vraw 0 2200u
C2 vraw 0 2200u
Rbleed vraw 0 4.7k
* reference: 13 V zener, RC filtered
Rz vraw nz 1k
Dz 0 nz ZMOD
Cz nz 0 100u
* Darlington pass with current clamp
Q1 vraw nz bq2 BC547B
Q2 vraw bq2 sense TIP41C
Rsense sense vout 0.33
Qlim nz sense vout BC547B
Dprot vout vraw DMOD
Cout vout 0 220u
Rled vout led 1k
Dled led 0 LEDR
* DC-in bypass path
Vdc dcin 0 DC 0
Rdcin dcin dcin2 0.05
Ddc dcin2 vout SB540
Rload vout 0 120
.model DMOD D(IS=2e-7 N=1.9 RS=0.015 CJO=80p TT=2n BV=400)
.model SB540 D(IS=5e-6 N=1.1 RS=0.02 CJO=200p TT=1n BV=40)
.model ZMOD D(IS=1e-11 N=1.2 RS=2 BV=13 IBV=5m CJO=50p TT=2n)
.model LEDR D(IS=1e-20 N=1.8 RS=10 CJO=20p)
.model BC547B NPN(IS=1.8e-14 BF=290 VAF=80 IKF=0.3 RB=10 RE=0.2 RC=0.5 CJE=12p CJC=4p TF=0.4n)
.model TIP41C NPN(IS=1e-12 BF=60 VAF=100 IKF=4 RB=0.5 RE=0.03 RC=0.05 CJE=300p CJC=150p TF=20n)
.control
foreach vs 16.97 21.21
  alter @Vac[sin] = [ 0 $vs 50 ]
  foreach rl 120 30 15 10
    alter Rload = $rl
    tran 0.2m 700m 550m
    meas tran vrmin MIN v(vraw) from=0.6 to=0.7
    meas tran vomin MIN v(vout) from=0.6 to=0.7
    meas tran vomax MAX v(vout) from=0.6 to=0.7
    meas tran vodc AVG v(vout) from=0.6 to=0.7
    meas tran iac RMS i(Vac) from=0.6 to=0.7
    let pq2v = (v(vraw)-v(sense))*v(sense,vout)/0.33
    meas tran pq2 AVG pq2v from=0.6 to=0.7
    let rip = (vomax-vomin)*1000
    let il = vodc/$rl
    echo RESULT ac vs=$vs rl=$rl vraw_trough=$&vrmin vout=$&vodc ripple_mV=$&rip iload=$&il iac_rms=$&iac pq2=$&pq2
  end
end
* short circuit / current clamp
alter @Vac[sin] = [ 0 21.21 50 ]
alter Rload = 0.5
tran 0.2m 700m 550m
meas tran vodc AVG v(vout) from=0.6 to=0.7
let pq2v = (v(vraw)-v(sense))*v(sense,vout)/0.33
meas tran pq2 AVG pq2v from=0.6 to=0.7
meas tran vrawm AVG v(vraw) from=0.6 to=0.7
let il = vodc/0.5
echo RESULT clamp vraw=$&vrawm rl=0.5 vout=$&vodc iload=$&il pq2=$&pq2
* DC-in only: no AC, 12 V on the DC terminal
alter @Vac[sin] = [ 0 0 50 ]
alter Vdc = 12
foreach rl 120 15
  alter Rload = $rl
  tran 0.2m 300m 250m
  meas tran vodc AVG v(vout) from=0.26 to=0.3
  meas tran vraw AVG v(vraw) from=0.26 to=0.3
  let vebv = v(vout)-v(bq2)
  let veb1v = v(bq2)-v(nz)
  meas tran veb AVG vebv from=0.26 to=0.3
  meas tran veb1 AVG veb1v from=0.26 to=0.3
  echo RESULT dconly rl=$rl vout=$&vodc vraw=$&vraw q2_veb_rev=$&veb q1_veb_rev=$&veb1
end
* both present: 15 VAC and 12 V DC
alter @Vac[sin] = [ 0 21.21 50 ]
alter Rload = 15
tran 0.2m 700m 550m
meas tran vodc AVG v(vout) from=0.6 to=0.7
meas tran idc AVG i(Vdc) from=0.6 to=0.7
echo RESULT both rl=15 vout=$&vodc i_from_dcin=$&idc
quit
.endc
.end
