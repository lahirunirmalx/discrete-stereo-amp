* PSU release 2: closed-loop series regulator. Bridge + 2x2200u as before; error amplifier Q4 compares a divider
* of VOUT (R_a + trimmer / R_b) with a 5.6 V zener fed from VOUT; Q4 collector pulls the driver base, which is
* fed from VRAW through R_drive. BC547 + TIP41C pass pair, 0.33 R clamp on the driver base, 1N4007 across the
* pass pair, SB540 DC-in bypass. Set point 12.0 V.
.options RELTOL=0.005 ABSTOL=1e-10 VNTOL=1e-7 CHGTOL=1e-14
.options TRTOL=7 ITL1=500 ITL4=500 GMIN=1e-11
Vac ac0 ac2 SIN(0 21.21 50)
Rfuse ac0 ac1 0.02
Rw ac2 ac2w 0.8
D1 ac1 vraw DMOD
D2 ac2w vraw DMOD
D3 0 ac1 DMOD
D4 0 ac2w DMOD
C1 vraw 0 2200u
C2 vraw 0 2200u
Rbleed vraw 0 4.7k
* drive and pass
Rdrive vraw bq1 2.2k
Q1 vraw bq1 bq2 BC547B
Q2 vraw bq2 sense TIP41C
Rsense sense vout 0.33
Qlim bq1 sense vout BC547B
Dprot vout vraw DMOD
Cout vout 0 220u
Cout2 vout 0 100n
* reference from the regulated output, error amplifier
Rz vout nz 1k
Dz 0 nz ZMOD
Cz nz 0 10u
Ra vout ra 8.2k
RV ra fb 900
Rb fb 0 10k
Q4 bq1 fb nz BC547B
Cc bq1 fb 47n
Cfb vout fb 100n
Rled vout led 1k
Dled led 0 LEDR
* DC-in path and load
Vdc dcin 0 DC 0
Rdcin dcin dcin2 0.05
Ddc dcin2 vout SB540
Rload vout 0 120
Sstep vout stp stpc 0 SW
Rstep stp 0 13.3
Vstep stpc 0 PULSE(0 5 0.62 1u 1u 40m 1)
.model SW SW(RON=0.01 ROFF=1e9 VT=2.5)
.model DMOD D(IS=2e-7 N=1.9 RS=0.015 CJO=80p TT=2n BV=400)
.model SB540 D(IS=5e-6 N=1.1 RS=0.02 CJO=200p TT=1n BV=40)
.model ZMOD D(IS=1e-11 N=1.2 RS=2 BV=5.6 IBV=5m CJO=50p TT=2n)
.model LEDR D(IS=1e-20 N=1.8 RS=10 CJO=20p)
.model BC547B NPN(IS=1.8e-14 BF=290 VAF=80 IKF=0.3 RB=10 RE=0.2 RC=0.5 CJE=12p CJC=4p TF=0.4n)
.model TIP41C NPN(IS=1e-12 BF=60 VAF=100 IKF=4 RB=0.5 RE=0.03 RC=0.05 CJE=300p CJC=150p TF=20n)
.control
foreach vs 16.97 21.21
  alter @Vac[sin] = [ 0 $vs 50 ]
  foreach rl 120 30 15 10
    alter Rload = $rl
    tran 0.2m 600m 450m
    meas tran vrmin MIN v(vraw) from=0.5 to=0.6
    meas tran vomin MIN v(vout) from=0.5 to=0.6
    meas tran vomax MAX v(vout) from=0.5 to=0.6
    meas tran vodc AVG v(vout) from=0.5 to=0.6
    meas tran iac RMS i(Vac) from=0.5 to=0.6
    let pq2v = (v(vraw)-v(sense))*v(sense,vout)/0.33
    meas tran pq2 AVG pq2v from=0.5 to=0.6
    let rip = (vomax-vomin)*1000
    let il = vodc/$rl
    echo RESULT ac vs=$vs rl=$rl vraw_trough=$&vrmin vout=$&vodc ripple_mV=$&rip iload=$&il iac_rms=$&iac pq2=$&pq2
  end
end
* load step 0.1 A -> 1 A -> 0.1 A at 15 VAC (switch adds 13.3 ohm in parallel from 620 to 660 ms)
alter @Vac[sin] = [ 0 21.21 50 ]
alter Rload = 120
tran 0.1m 700m 600m
meas tran vbefore AVG v(vout) from=0.60 to=0.62
meas tran vduring AVG v(vout) from=0.63 to=0.66
meas tran vdip MIN v(vout) from=0.62 to=0.625
meas tran vpeak MAX v(vout) from=0.66 to=0.665
echo RESULT step vbefore=$&vbefore vduring=$&vduring dip=$&vdip overshoot=$&vpeak
* short circuit
alter Rload = 0.5
tran 0.2m 600m 450m
meas tran vodc AVG v(vout) from=0.5 to=0.6
let pq2v = (v(vraw)-v(sense))*v(sense,vout)/0.33
meas tran pq2 AVG pq2v from=0.5 to=0.6
let il = vodc/0.5
echo RESULT clamp vout=$&vodc iload=$&il pq2=$&pq2
* DC-in only
alter @Vac[sin] = [ 0 0 50 ]
alter Vdc = 12
foreach rl 120 15
  alter Rload = $rl
  tran 0.2m 300m 250m
  meas tran vodc AVG v(vout) from=0.26 to=0.3
  meas tran vraw AVG v(vraw) from=0.26 to=0.3
  let vebv = v(vout)-v(bq2)
  let veb1v = v(bq2)-v(bq1)
  meas tran veb AVG vebv from=0.26 to=0.3
  meas tran veb1 AVG veb1v from=0.26 to=0.3
  echo RESULT dconly rl=$rl vout=$&vodc vraw=$&vraw q2_veb_rev=$&veb q1_veb_rev=$&veb1
end
alter @Vac[sin] = [ 0 21.21 50 ]
alter Rload = 15
tran 0.2m 600m 450m
meas tran vodc AVG v(vout) from=0.5 to=0.6
meas tran idc AVG i(Vdc) from=0.5 to=0.6
echo RESULT both rl=15 vout=$&vodc i_from_dcin=$&idc
quit
.endc
.end
