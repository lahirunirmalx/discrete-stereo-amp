* DC check of the closed-loop regulator with a fixed raw rail
Vraw vraw 0 DC 16
Rdrive vraw bq1 2.2k
Q1 vraw bq1 bq2 BC547B
Q2 vraw bq2 sense TIP41C
Rsense sense vout 0.33
Qlim bq1 sense vout BC547B
Cout vout 0 220u
Rz vout nz 1k
Dz 0 nz ZMOD
Ra vout fb 8.2k
RV fb fb2 900
Rb fb2 0 10k
Q4 bq1 fb nz BC547B
Rload vout 0 120
.model ZMOD D(IS=1e-11 N=1.2 RS=2 BV=5.6 IBV=5m CJO=50p TT=2n)
.model BC547B NPN(IS=1.8e-14 BF=290 VAF=80 IKF=0.3 RB=10 RE=0.2 RC=0.5 CJE=12p CJC=4p TF=0.4n)
.model TIP41C NPN(IS=1e-12 BF=60 VAF=100 IKF=4 RB=0.5 RE=0.03 RC=0.05 CJE=300p CJC=150p TF=20n)
.control
foreach rl 120 12
  alter Rload = $rl
  op
  echo RESULT rl=$rl vout=$&v(vout) fb=$&v(fb) nz=$&v(nz) bq1=$&v(bq1) bq2=$&v(bq2) iq4=$&@q4[ic]
end
foreach vr 13 14 16 19
  alter Vraw = $vr
  alter Rload = 12
  op
  echo RESULT vraw=$vr rl=12 vout=$&v(vout)
end
quit
.endc
.end
